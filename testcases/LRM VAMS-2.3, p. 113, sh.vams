module sh (in, out, smpl);
	parameter real thresh = 0;
	parameter integer dir = +1 from [-1:0] exclude 0;
	output out;
	input in, smpl;
	electrical in, out, smpl;
	real state;

	analog begin
		@(cross(V(smpl) - thresh, dir))
			state = V(in);
		V(out) <+ transition(state, 0, 10n);
	end
endmodule

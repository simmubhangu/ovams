module not_gate(in, out);
	input in;
	output out;
	reg out;
`ifdef __VAMS_ENABLE__
	parameter integer del = 1 from [1:100];
`else
	parameter del = 1;
`endif

	always @ in
		out = #del !in;
endmodule

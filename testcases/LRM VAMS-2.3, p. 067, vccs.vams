module vccs(pout,nout,pin,nin);
	inout pout, nout, pin, nin;
	electrical pout, nout, pin, nin;
	parameter real k = 1.0;
	real vin, one, minusone, zero;
	analog begin
		vin = V(pin,nin);
		one = ddx(vin, V(pin));
		minusone = ddx(vin, V(nin));
		zero = ddx(vin, V(pout));
		I(pout,nout) <+ k * vin;
	end
endmodule

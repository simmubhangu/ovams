module m1; // module definition with no `begin_keywords directive
	/* ... */
endmodule

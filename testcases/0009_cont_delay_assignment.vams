`timescale 1 ps / 1 ps

module ckmux ( clko1, clk1, clk2, f1, f2 );
    output    clko1;
    input     clk1, clk2, f1, f2;

    reg       dclk1ff;
    wire      dclk1;

    initial begin
        dclk1ff = 1'b0;
        forever @( negedge clk1 ) dclk1ff <= #50 ~ dclk1ff;
    end

    assign #50 dclk1 = f2 ? dclk1ff : clk2;
    assign #50 clko1 = f1 ? dclk1   : clk1;  //break
endmodule

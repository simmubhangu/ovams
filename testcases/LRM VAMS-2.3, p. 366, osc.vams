module osc (out, gnd);
	electrical out, gnd;
	ecpOsc Osc1 (out, gnd);
endmodule

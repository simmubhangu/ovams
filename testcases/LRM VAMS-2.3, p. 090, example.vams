module example;
	parameter integer p1 = 1;
	real moduleVar;

	analog begin
		begin: myscope
			parameter real p2 = p1;
			real localVar = 1.5 * p2;
		end
		moduleVar = myscope.localVar;
	end
endmodule

module top;
	example #(.p1(4)) inst1(); // allowed
	//example #(.myscope.p2(4)) inst2(); // error
endmodule

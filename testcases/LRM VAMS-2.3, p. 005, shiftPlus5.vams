module shiftPlus5(in, out);
	input in;
	output out;
	voltage in, out; //voltage is a signal flow
			 //discipline compatible with
			 //electrical, but having a
			 //potential nature only
	analog begin
		V(out) <+ 5.0 + V(in);
	end
endmodule

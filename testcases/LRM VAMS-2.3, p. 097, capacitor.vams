module capacitor(p, n);
	inout p, n;
	electrical p, n;
	parameter real c = 0;
	analog
		I(p,n) <+ c*ddt(V(p, n)); // unnamed branch p,n
endmodule

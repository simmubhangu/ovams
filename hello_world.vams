module hello_world ;

 initial begin
 $display_p ("Hello World");
 #10  $finish;
 end
 endmodule // End of Module hello_world
